.meas tran vdout1_0ck40 FIND v(dout1_0) AT=50.05n

.meas tran vdout1_1ck40 FIND v(dout1_1) AT=50.05n

.meas tran vdout1_2ck40 FIND v(dout1_2) AT=50.05n

.meas tran vdout1_3ck40 FIND v(dout1_3) AT=50.05n

.meas tran vdout1_4ck40 FIND v(dout1_4) AT=50.05n

.meas tran vdout1_5ck40 FIND v(dout1_5) AT=50.05n

.meas tran vdout1_6ck40 FIND v(dout1_6) AT=50.05n

.meas tran vdout1_7ck40 FIND v(dout1_7) AT=50.05n

.meas tran vdout1_8ck40 FIND v(dout1_8) AT=50.05n

.meas tran vdout1_9ck40 FIND v(dout1_9) AT=50.05n

.meas tran vdout1_10ck40 FIND v(dout1_10) AT=50.05n

.meas tran vdout1_11ck40 FIND v(dout1_11) AT=50.05n

.meas tran vdout1_0ck70 FIND v(dout1_0) AT=80.05n

.meas tran vdout1_1ck70 FIND v(dout1_1) AT=80.05n

.meas tran vdout1_2ck70 FIND v(dout1_2) AT=80.05n

.meas tran vdout1_3ck70 FIND v(dout1_3) AT=80.05n

.meas tran vdout1_4ck70 FIND v(dout1_4) AT=80.05n

.meas tran vdout1_5ck70 FIND v(dout1_5) AT=80.05n

.meas tran vdout1_6ck70 FIND v(dout1_6) AT=80.05n

.meas tran vdout1_7ck70 FIND v(dout1_7) AT=80.05n

.meas tran vdout1_8ck70 FIND v(dout1_8) AT=80.05n

.meas tran vdout1_9ck70 FIND v(dout1_9) AT=80.05n

.meas tran vdout1_10ck70 FIND v(dout1_10) AT=80.05n

.meas tran vdout1_11ck70 FIND v(dout1_11) AT=80.05n

.meas tran vdout1_0ck100 FIND v(dout1_0) AT=110.05n

.meas tran vdout1_1ck100 FIND v(dout1_1) AT=110.05n

.meas tran vdout1_2ck100 FIND v(dout1_2) AT=110.05n

.meas tran vdout1_3ck100 FIND v(dout1_3) AT=110.05n

.meas tran vdout1_4ck100 FIND v(dout1_4) AT=110.05n

.meas tran vdout1_5ck100 FIND v(dout1_5) AT=110.05n

.meas tran vdout1_6ck100 FIND v(dout1_6) AT=110.05n

.meas tran vdout1_7ck100 FIND v(dout1_7) AT=110.05n

.meas tran vdout1_8ck100 FIND v(dout1_8) AT=110.05n

.meas tran vdout1_9ck100 FIND v(dout1_9) AT=110.05n

.meas tran vdout1_10ck100 FIND v(dout1_10) AT=110.05n

.meas tran vdout1_11ck100 FIND v(dout1_11) AT=110.05n

.meas tran vdout1_0ck110 FIND v(dout1_0) AT=120.05n

.meas tran vdout1_1ck110 FIND v(dout1_1) AT=120.05n

.meas tran vdout1_2ck110 FIND v(dout1_2) AT=120.05n

.meas tran vdout1_3ck110 FIND v(dout1_3) AT=120.05n

.meas tran vdout1_4ck110 FIND v(dout1_4) AT=120.05n

.meas tran vdout1_5ck110 FIND v(dout1_5) AT=120.05n

.meas tran vdout1_6ck110 FIND v(dout1_6) AT=120.05n

.meas tran vdout1_7ck110 FIND v(dout1_7) AT=120.05n

.meas tran vdout1_8ck110 FIND v(dout1_8) AT=120.05n

.meas tran vdout1_9ck110 FIND v(dout1_9) AT=120.05n

.meas tran vdout1_10ck110 FIND v(dout1_10) AT=120.05n

.meas tran vdout1_11ck110 FIND v(dout1_11) AT=120.05n

.meas tran vdout1_0ck140 FIND v(dout1_0) AT=150.05n

.meas tran vdout1_1ck140 FIND v(dout1_1) AT=150.05n

.meas tran vdout1_2ck140 FIND v(dout1_2) AT=150.05n

.meas tran vdout1_3ck140 FIND v(dout1_3) AT=150.05n

.meas tran vdout1_4ck140 FIND v(dout1_4) AT=150.05n

.meas tran vdout1_5ck140 FIND v(dout1_5) AT=150.05n

.meas tran vdout1_6ck140 FIND v(dout1_6) AT=150.05n

.meas tran vdout1_7ck140 FIND v(dout1_7) AT=150.05n

.meas tran vdout1_8ck140 FIND v(dout1_8) AT=150.05n

.meas tran vdout1_9ck140 FIND v(dout1_9) AT=150.05n

.meas tran vdout1_10ck140 FIND v(dout1_10) AT=150.05n

.meas tran vdout1_11ck140 FIND v(dout1_11) AT=150.05n

.meas tran vdout1_0ck160 FIND v(dout1_0) AT=170.05n

.meas tran vdout1_1ck160 FIND v(dout1_1) AT=170.05n

.meas tran vdout1_2ck160 FIND v(dout1_2) AT=170.05n

.meas tran vdout1_3ck160 FIND v(dout1_3) AT=170.05n

.meas tran vdout1_4ck160 FIND v(dout1_4) AT=170.05n

.meas tran vdout1_5ck160 FIND v(dout1_5) AT=170.05n

.meas tran vdout1_6ck160 FIND v(dout1_6) AT=170.05n

.meas tran vdout1_7ck160 FIND v(dout1_7) AT=170.05n

.meas tran vdout1_8ck160 FIND v(dout1_8) AT=170.05n

.meas tran vdout1_9ck160 FIND v(dout1_9) AT=170.05n

.meas tran vdout1_10ck160 FIND v(dout1_10) AT=170.05n

.meas tran vdout1_11ck160 FIND v(dout1_11) AT=170.05n

.meas tran vdout1_0ck170 FIND v(dout1_0) AT=180.05n

.meas tran vdout1_1ck170 FIND v(dout1_1) AT=180.05n

.meas tran vdout1_2ck170 FIND v(dout1_2) AT=180.05n

.meas tran vdout1_3ck170 FIND v(dout1_3) AT=180.05n

.meas tran vdout1_4ck170 FIND v(dout1_4) AT=180.05n

.meas tran vdout1_5ck170 FIND v(dout1_5) AT=180.05n

.meas tran vdout1_6ck170 FIND v(dout1_6) AT=180.05n

.meas tran vdout1_7ck170 FIND v(dout1_7) AT=180.05n

.meas tran vdout1_8ck170 FIND v(dout1_8) AT=180.05n

.meas tran vdout1_9ck170 FIND v(dout1_9) AT=180.05n

.meas tran vdout1_10ck170 FIND v(dout1_10) AT=180.05n

.meas tran vdout1_11ck170 FIND v(dout1_11) AT=180.05n

.meas tran vdout1_0ck180 FIND v(dout1_0) AT=190.05n

.meas tran vdout1_1ck180 FIND v(dout1_1) AT=190.05n

.meas tran vdout1_2ck180 FIND v(dout1_2) AT=190.05n

.meas tran vdout1_3ck180 FIND v(dout1_3) AT=190.05n

.meas tran vdout1_4ck180 FIND v(dout1_4) AT=190.05n

.meas tran vdout1_5ck180 FIND v(dout1_5) AT=190.05n

.meas tran vdout1_6ck180 FIND v(dout1_6) AT=190.05n

.meas tran vdout1_7ck180 FIND v(dout1_7) AT=190.05n

.meas tran vdout1_8ck180 FIND v(dout1_8) AT=190.05n

.meas tran vdout1_9ck180 FIND v(dout1_9) AT=190.05n

.meas tran vdout1_10ck180 FIND v(dout1_10) AT=190.05n

.meas tran vdout1_11ck180 FIND v(dout1_11) AT=190.05n

.meas tran vdout1_0ck210 FIND v(dout1_0) AT=220.05n

.meas tran vdout1_1ck210 FIND v(dout1_1) AT=220.05n

.meas tran vdout1_2ck210 FIND v(dout1_2) AT=220.05n

.meas tran vdout1_3ck210 FIND v(dout1_3) AT=220.05n

.meas tran vdout1_4ck210 FIND v(dout1_4) AT=220.05n

.meas tran vdout1_5ck210 FIND v(dout1_5) AT=220.05n

.meas tran vdout1_6ck210 FIND v(dout1_6) AT=220.05n

.meas tran vdout1_7ck210 FIND v(dout1_7) AT=220.05n

.meas tran vdout1_8ck210 FIND v(dout1_8) AT=220.05n

.meas tran vdout1_9ck210 FIND v(dout1_9) AT=220.05n

.meas tran vdout1_10ck210 FIND v(dout1_10) AT=220.05n

.meas tran vdout1_11ck210 FIND v(dout1_11) AT=220.05n

.meas tran vdout1_0ck230 FIND v(dout1_0) AT=240.05n

.meas tran vdout1_1ck230 FIND v(dout1_1) AT=240.05n

.meas tran vdout1_2ck230 FIND v(dout1_2) AT=240.05n

.meas tran vdout1_3ck230 FIND v(dout1_3) AT=240.05n

.meas tran vdout1_4ck230 FIND v(dout1_4) AT=240.05n

.meas tran vdout1_5ck230 FIND v(dout1_5) AT=240.05n

.meas tran vdout1_6ck230 FIND v(dout1_6) AT=240.05n

.meas tran vdout1_7ck230 FIND v(dout1_7) AT=240.05n

.meas tran vdout1_8ck230 FIND v(dout1_8) AT=240.05n

.meas tran vdout1_9ck230 FIND v(dout1_9) AT=240.05n

.meas tran vdout1_10ck230 FIND v(dout1_10) AT=240.05n

.meas tran vdout1_11ck230 FIND v(dout1_11) AT=240.05n

.meas tran vdout1_0ck240 FIND v(dout1_0) AT=250.05n

.meas tran vdout1_1ck240 FIND v(dout1_1) AT=250.05n

.meas tran vdout1_2ck240 FIND v(dout1_2) AT=250.05n

.meas tran vdout1_3ck240 FIND v(dout1_3) AT=250.05n

.meas tran vdout1_4ck240 FIND v(dout1_4) AT=250.05n

.meas tran vdout1_5ck240 FIND v(dout1_5) AT=250.05n

.meas tran vdout1_6ck240 FIND v(dout1_6) AT=250.05n

.meas tran vdout1_7ck240 FIND v(dout1_7) AT=250.05n

.meas tran vdout1_8ck240 FIND v(dout1_8) AT=250.05n

.meas tran vdout1_9ck240 FIND v(dout1_9) AT=250.05n

.meas tran vdout1_10ck240 FIND v(dout1_10) AT=250.05n

.meas tran vdout1_11ck240 FIND v(dout1_11) AT=250.05n

.meas tran vdout1_0ck310 FIND v(dout1_0) AT=320.05n

.meas tran vdout1_1ck310 FIND v(dout1_1) AT=320.05n

.meas tran vdout1_2ck310 FIND v(dout1_2) AT=320.05n

.meas tran vdout1_3ck310 FIND v(dout1_3) AT=320.05n

.meas tran vdout1_4ck310 FIND v(dout1_4) AT=320.05n

.meas tran vdout1_5ck310 FIND v(dout1_5) AT=320.05n

.meas tran vdout1_6ck310 FIND v(dout1_6) AT=320.05n

.meas tran vdout1_7ck310 FIND v(dout1_7) AT=320.05n

.meas tran vdout1_8ck310 FIND v(dout1_8) AT=320.05n

.meas tran vdout1_9ck310 FIND v(dout1_9) AT=320.05n

.meas tran vdout1_10ck310 FIND v(dout1_10) AT=320.05n

.meas tran vdout1_11ck310 FIND v(dout1_11) AT=320.05n

.meas tran vdout1_0ck330 FIND v(dout1_0) AT=340.05n

.meas tran vdout1_1ck330 FIND v(dout1_1) AT=340.05n

.meas tran vdout1_2ck330 FIND v(dout1_2) AT=340.05n

.meas tran vdout1_3ck330 FIND v(dout1_3) AT=340.05n

.meas tran vdout1_4ck330 FIND v(dout1_4) AT=340.05n

.meas tran vdout1_5ck330 FIND v(dout1_5) AT=340.05n

.meas tran vdout1_6ck330 FIND v(dout1_6) AT=340.05n

.meas tran vdout1_7ck330 FIND v(dout1_7) AT=340.05n

.meas tran vdout1_8ck330 FIND v(dout1_8) AT=340.05n

.meas tran vdout1_9ck330 FIND v(dout1_9) AT=340.05n

.meas tran vdout1_10ck330 FIND v(dout1_10) AT=340.05n

.meas tran vdout1_11ck330 FIND v(dout1_11) AT=340.05n

.meas tran vdout1_0ck350 FIND v(dout1_0) AT=360.05n

.meas tran vdout1_1ck350 FIND v(dout1_1) AT=360.05n

.meas tran vdout1_2ck350 FIND v(dout1_2) AT=360.05n

.meas tran vdout1_3ck350 FIND v(dout1_3) AT=360.05n

.meas tran vdout1_4ck350 FIND v(dout1_4) AT=360.05n

.meas tran vdout1_5ck350 FIND v(dout1_5) AT=360.05n

.meas tran vdout1_6ck350 FIND v(dout1_6) AT=360.05n

.meas tran vdout1_7ck350 FIND v(dout1_7) AT=360.05n

.meas tran vdout1_8ck350 FIND v(dout1_8) AT=360.05n

.meas tran vdout1_9ck350 FIND v(dout1_9) AT=360.05n

.meas tran vdout1_10ck350 FIND v(dout1_10) AT=360.05n

.meas tran vdout1_11ck350 FIND v(dout1_11) AT=360.05n

.meas tran vdout1_0ck360 FIND v(dout1_0) AT=370.05n

.meas tran vdout1_1ck360 FIND v(dout1_1) AT=370.05n

.meas tran vdout1_2ck360 FIND v(dout1_2) AT=370.05n

.meas tran vdout1_3ck360 FIND v(dout1_3) AT=370.05n

.meas tran vdout1_4ck360 FIND v(dout1_4) AT=370.05n

.meas tran vdout1_5ck360 FIND v(dout1_5) AT=370.05n

.meas tran vdout1_6ck360 FIND v(dout1_6) AT=370.05n

.meas tran vdout1_7ck360 FIND v(dout1_7) AT=370.05n

.meas tran vdout1_8ck360 FIND v(dout1_8) AT=370.05n

.meas tran vdout1_9ck360 FIND v(dout1_9) AT=370.05n

.meas tran vdout1_10ck360 FIND v(dout1_10) AT=370.05n

.meas tran vdout1_11ck360 FIND v(dout1_11) AT=370.05n

.meas tran vdout1_0ck390 FIND v(dout1_0) AT=400.05n

.meas tran vdout1_1ck390 FIND v(dout1_1) AT=400.05n

.meas tran vdout1_2ck390 FIND v(dout1_2) AT=400.05n

.meas tran vdout1_3ck390 FIND v(dout1_3) AT=400.05n

.meas tran vdout1_4ck390 FIND v(dout1_4) AT=400.05n

.meas tran vdout1_5ck390 FIND v(dout1_5) AT=400.05n

.meas tran vdout1_6ck390 FIND v(dout1_6) AT=400.05n

.meas tran vdout1_7ck390 FIND v(dout1_7) AT=400.05n

.meas tran vdout1_8ck390 FIND v(dout1_8) AT=400.05n

.meas tran vdout1_9ck390 FIND v(dout1_9) AT=400.05n

.meas tran vdout1_10ck390 FIND v(dout1_10) AT=400.05n

.meas tran vdout1_11ck390 FIND v(dout1_11) AT=400.05n

.meas tran vdout1_0ck400 FIND v(dout1_0) AT=410.05n

.meas tran vdout1_1ck400 FIND v(dout1_1) AT=410.05n

.meas tran vdout1_2ck400 FIND v(dout1_2) AT=410.05n

.meas tran vdout1_3ck400 FIND v(dout1_3) AT=410.05n

.meas tran vdout1_4ck400 FIND v(dout1_4) AT=410.05n

.meas tran vdout1_5ck400 FIND v(dout1_5) AT=410.05n

.meas tran vdout1_6ck400 FIND v(dout1_6) AT=410.05n

.meas tran vdout1_7ck400 FIND v(dout1_7) AT=410.05n

.meas tran vdout1_8ck400 FIND v(dout1_8) AT=410.05n

.meas tran vdout1_9ck400 FIND v(dout1_9) AT=410.05n

.meas tran vdout1_10ck400 FIND v(dout1_10) AT=410.05n

.meas tran vdout1_11ck400 FIND v(dout1_11) AT=410.05n

.meas tran vdout1_0ck430 FIND v(dout1_0) AT=440.05n

.meas tran vdout1_1ck430 FIND v(dout1_1) AT=440.05n

.meas tran vdout1_2ck430 FIND v(dout1_2) AT=440.05n

.meas tran vdout1_3ck430 FIND v(dout1_3) AT=440.05n

.meas tran vdout1_4ck430 FIND v(dout1_4) AT=440.05n

.meas tran vdout1_5ck430 FIND v(dout1_5) AT=440.05n

.meas tran vdout1_6ck430 FIND v(dout1_6) AT=440.05n

.meas tran vdout1_7ck430 FIND v(dout1_7) AT=440.05n

.meas tran vdout1_8ck430 FIND v(dout1_8) AT=440.05n

.meas tran vdout1_9ck430 FIND v(dout1_9) AT=440.05n

.meas tran vdout1_10ck430 FIND v(dout1_10) AT=440.05n

.meas tran vdout1_11ck430 FIND v(dout1_11) AT=440.05n

.meas tran vdout1_0ck440 FIND v(dout1_0) AT=450.05n

.meas tran vdout1_1ck440 FIND v(dout1_1) AT=450.05n

.meas tran vdout1_2ck440 FIND v(dout1_2) AT=450.05n

.meas tran vdout1_3ck440 FIND v(dout1_3) AT=450.05n

.meas tran vdout1_4ck440 FIND v(dout1_4) AT=450.05n

.meas tran vdout1_5ck440 FIND v(dout1_5) AT=450.05n

.meas tran vdout1_6ck440 FIND v(dout1_6) AT=450.05n

.meas tran vdout1_7ck440 FIND v(dout1_7) AT=450.05n

.meas tran vdout1_8ck440 FIND v(dout1_8) AT=450.05n

.meas tran vdout1_9ck440 FIND v(dout1_9) AT=450.05n

.meas tran vdout1_10ck440 FIND v(dout1_10) AT=450.05n

.meas tran vdout1_11ck440 FIND v(dout1_11) AT=450.05n

.meas tran vdout1_0ck460 FIND v(dout1_0) AT=470.05n

.meas tran vdout1_1ck460 FIND v(dout1_1) AT=470.05n

.meas tran vdout1_2ck460 FIND v(dout1_2) AT=470.05n

.meas tran vdout1_3ck460 FIND v(dout1_3) AT=470.05n

.meas tran vdout1_4ck460 FIND v(dout1_4) AT=470.05n

.meas tran vdout1_5ck460 FIND v(dout1_5) AT=470.05n

.meas tran vdout1_6ck460 FIND v(dout1_6) AT=470.05n

.meas tran vdout1_7ck460 FIND v(dout1_7) AT=470.05n

.meas tran vdout1_8ck460 FIND v(dout1_8) AT=470.05n

.meas tran vdout1_9ck460 FIND v(dout1_9) AT=470.05n

.meas tran vdout1_10ck460 FIND v(dout1_10) AT=470.05n

.meas tran vdout1_11ck460 FIND v(dout1_11) AT=470.05n

.meas tran vdout1_0ck490 FIND v(dout1_0) AT=500.05n

.meas tran vdout1_1ck490 FIND v(dout1_1) AT=500.05n

.meas tran vdout1_2ck490 FIND v(dout1_2) AT=500.05n

.meas tran vdout1_3ck490 FIND v(dout1_3) AT=500.05n

.meas tran vdout1_4ck490 FIND v(dout1_4) AT=500.05n

.meas tran vdout1_5ck490 FIND v(dout1_5) AT=500.05n

.meas tran vdout1_6ck490 FIND v(dout1_6) AT=500.05n

.meas tran vdout1_7ck490 FIND v(dout1_7) AT=500.05n

.meas tran vdout1_8ck490 FIND v(dout1_8) AT=500.05n

.meas tran vdout1_9ck490 FIND v(dout1_9) AT=500.05n

.meas tran vdout1_10ck490 FIND v(dout1_10) AT=500.05n

.meas tran vdout1_11ck490 FIND v(dout1_11) AT=500.05n

.meas tran vdout1_0ck500 FIND v(dout1_0) AT=510.05n

.meas tran vdout1_1ck500 FIND v(dout1_1) AT=510.05n

.meas tran vdout1_2ck500 FIND v(dout1_2) AT=510.05n

.meas tran vdout1_3ck500 FIND v(dout1_3) AT=510.05n

.meas tran vdout1_4ck500 FIND v(dout1_4) AT=510.05n

.meas tran vdout1_5ck500 FIND v(dout1_5) AT=510.05n

.meas tran vdout1_6ck500 FIND v(dout1_6) AT=510.05n

.meas tran vdout1_7ck500 FIND v(dout1_7) AT=510.05n

.meas tran vdout1_8ck500 FIND v(dout1_8) AT=510.05n

.meas tran vdout1_9ck500 FIND v(dout1_9) AT=510.05n

.meas tran vdout1_10ck500 FIND v(dout1_10) AT=510.05n

.meas tran vdout1_11ck500 FIND v(dout1_11) AT=510.05n

.meas tran vdout1_0ck530 FIND v(dout1_0) AT=540.05n

.meas tran vdout1_1ck530 FIND v(dout1_1) AT=540.05n

.meas tran vdout1_2ck530 FIND v(dout1_2) AT=540.05n

.meas tran vdout1_3ck530 FIND v(dout1_3) AT=540.05n

.meas tran vdout1_4ck530 FIND v(dout1_4) AT=540.05n

.meas tran vdout1_5ck530 FIND v(dout1_5) AT=540.05n

.meas tran vdout1_6ck530 FIND v(dout1_6) AT=540.05n

.meas tran vdout1_7ck530 FIND v(dout1_7) AT=540.05n

.meas tran vdout1_8ck530 FIND v(dout1_8) AT=540.05n

.meas tran vdout1_9ck530 FIND v(dout1_9) AT=540.05n

.meas tran vdout1_10ck530 FIND v(dout1_10) AT=540.05n

.meas tran vdout1_11ck530 FIND v(dout1_11) AT=540.05n

.meas tran vdout1_0ck540 FIND v(dout1_0) AT=550.05n

.meas tran vdout1_1ck540 FIND v(dout1_1) AT=550.05n

.meas tran vdout1_2ck540 FIND v(dout1_2) AT=550.05n

.meas tran vdout1_3ck540 FIND v(dout1_3) AT=550.05n

.meas tran vdout1_4ck540 FIND v(dout1_4) AT=550.05n

.meas tran vdout1_5ck540 FIND v(dout1_5) AT=550.05n

.meas tran vdout1_6ck540 FIND v(dout1_6) AT=550.05n

.meas tran vdout1_7ck540 FIND v(dout1_7) AT=550.05n

.meas tran vdout1_8ck540 FIND v(dout1_8) AT=550.05n

.meas tran vdout1_9ck540 FIND v(dout1_9) AT=550.05n

.meas tran vdout1_10ck540 FIND v(dout1_10) AT=550.05n

.meas tran vdout1_11ck540 FIND v(dout1_11) AT=550.05n

.meas tran vdout1_0ck550 FIND v(dout1_0) AT=560.05n

.meas tran vdout1_1ck550 FIND v(dout1_1) AT=560.05n

.meas tran vdout1_2ck550 FIND v(dout1_2) AT=560.05n

.meas tran vdout1_3ck550 FIND v(dout1_3) AT=560.05n

.meas tran vdout1_4ck550 FIND v(dout1_4) AT=560.05n

.meas tran vdout1_5ck550 FIND v(dout1_5) AT=560.05n

.meas tran vdout1_6ck550 FIND v(dout1_6) AT=560.05n

.meas tran vdout1_7ck550 FIND v(dout1_7) AT=560.05n

.meas tran vdout1_8ck550 FIND v(dout1_8) AT=560.05n

.meas tran vdout1_9ck550 FIND v(dout1_9) AT=560.05n

.meas tran vdout1_10ck550 FIND v(dout1_10) AT=560.05n

.meas tran vdout1_11ck550 FIND v(dout1_11) AT=560.05n

.meas tran vdout1_0ck580 FIND v(dout1_0) AT=590.05n

.meas tran vdout1_1ck580 FIND v(dout1_1) AT=590.05n

.meas tran vdout1_2ck580 FIND v(dout1_2) AT=590.05n

.meas tran vdout1_3ck580 FIND v(dout1_3) AT=590.05n

.meas tran vdout1_4ck580 FIND v(dout1_4) AT=590.05n

.meas tran vdout1_5ck580 FIND v(dout1_5) AT=590.05n

.meas tran vdout1_6ck580 FIND v(dout1_6) AT=590.05n

.meas tran vdout1_7ck580 FIND v(dout1_7) AT=590.05n

.meas tran vdout1_8ck580 FIND v(dout1_8) AT=590.05n

.meas tran vdout1_9ck580 FIND v(dout1_9) AT=590.05n

.meas tran vdout1_10ck580 FIND v(dout1_10) AT=590.05n

.meas tran vdout1_11ck580 FIND v(dout1_11) AT=590.05n

.meas tran vdout1_0ck600 FIND v(dout1_0) AT=610.05n

.meas tran vdout1_1ck600 FIND v(dout1_1) AT=610.05n

.meas tran vdout1_2ck600 FIND v(dout1_2) AT=610.05n

.meas tran vdout1_3ck600 FIND v(dout1_3) AT=610.05n

.meas tran vdout1_4ck600 FIND v(dout1_4) AT=610.05n

.meas tran vdout1_5ck600 FIND v(dout1_5) AT=610.05n

.meas tran vdout1_6ck600 FIND v(dout1_6) AT=610.05n

.meas tran vdout1_7ck600 FIND v(dout1_7) AT=610.05n

.meas tran vdout1_8ck600 FIND v(dout1_8) AT=610.05n

.meas tran vdout1_9ck600 FIND v(dout1_9) AT=610.05n

.meas tran vdout1_10ck600 FIND v(dout1_10) AT=610.05n

.meas tran vdout1_11ck600 FIND v(dout1_11) AT=610.05n

.meas tran vdout1_0ck610 FIND v(dout1_0) AT=620.05n

.meas tran vdout1_1ck610 FIND v(dout1_1) AT=620.05n

.meas tran vdout1_2ck610 FIND v(dout1_2) AT=620.05n

.meas tran vdout1_3ck610 FIND v(dout1_3) AT=620.05n

.meas tran vdout1_4ck610 FIND v(dout1_4) AT=620.05n

.meas tran vdout1_5ck610 FIND v(dout1_5) AT=620.05n

.meas tran vdout1_6ck610 FIND v(dout1_6) AT=620.05n

.meas tran vdout1_7ck610 FIND v(dout1_7) AT=620.05n

.meas tran vdout1_8ck610 FIND v(dout1_8) AT=620.05n

.meas tran vdout1_9ck610 FIND v(dout1_9) AT=620.05n

.meas tran vdout1_10ck610 FIND v(dout1_10) AT=620.05n

.meas tran vdout1_11ck610 FIND v(dout1_11) AT=620.05n

.meas tran vdout1_0ck620 FIND v(dout1_0) AT=630.05n

.meas tran vdout1_1ck620 FIND v(dout1_1) AT=630.05n

.meas tran vdout1_2ck620 FIND v(dout1_2) AT=630.05n

.meas tran vdout1_3ck620 FIND v(dout1_3) AT=630.05n

.meas tran vdout1_4ck620 FIND v(dout1_4) AT=630.05n

.meas tran vdout1_5ck620 FIND v(dout1_5) AT=630.05n

.meas tran vdout1_6ck620 FIND v(dout1_6) AT=630.05n

.meas tran vdout1_7ck620 FIND v(dout1_7) AT=630.05n

.meas tran vdout1_8ck620 FIND v(dout1_8) AT=630.05n

.meas tran vdout1_9ck620 FIND v(dout1_9) AT=630.05n

.meas tran vdout1_10ck620 FIND v(dout1_10) AT=630.05n

.meas tran vdout1_11ck620 FIND v(dout1_11) AT=630.05n

.meas tran vdout1_0ck630 FIND v(dout1_0) AT=640.05n

.meas tran vdout1_1ck630 FIND v(dout1_1) AT=640.05n

.meas tran vdout1_2ck630 FIND v(dout1_2) AT=640.05n

.meas tran vdout1_3ck630 FIND v(dout1_3) AT=640.05n

.meas tran vdout1_4ck630 FIND v(dout1_4) AT=640.05n

.meas tran vdout1_5ck630 FIND v(dout1_5) AT=640.05n

.meas tran vdout1_6ck630 FIND v(dout1_6) AT=640.05n

.meas tran vdout1_7ck630 FIND v(dout1_7) AT=640.05n

.meas tran vdout1_8ck630 FIND v(dout1_8) AT=640.05n

.meas tran vdout1_9ck630 FIND v(dout1_9) AT=640.05n

.meas tran vdout1_10ck630 FIND v(dout1_10) AT=640.05n

.meas tran vdout1_11ck630 FIND v(dout1_11) AT=640.05n

.meas tran vdout1_0ck640 FIND v(dout1_0) AT=650.05n

.meas tran vdout1_1ck640 FIND v(dout1_1) AT=650.05n

.meas tran vdout1_2ck640 FIND v(dout1_2) AT=650.05n

.meas tran vdout1_3ck640 FIND v(dout1_3) AT=650.05n

.meas tran vdout1_4ck640 FIND v(dout1_4) AT=650.05n

.meas tran vdout1_5ck640 FIND v(dout1_5) AT=650.05n

.meas tran vdout1_6ck640 FIND v(dout1_6) AT=650.05n

.meas tran vdout1_7ck640 FIND v(dout1_7) AT=650.05n

.meas tran vdout1_8ck640 FIND v(dout1_8) AT=650.05n

.meas tran vdout1_9ck640 FIND v(dout1_9) AT=650.05n

.meas tran vdout1_10ck640 FIND v(dout1_10) AT=650.05n

.meas tran vdout1_11ck640 FIND v(dout1_11) AT=650.05n

.meas tran vdout1_0ck650 FIND v(dout1_0) AT=660.05n

.meas tran vdout1_1ck650 FIND v(dout1_1) AT=660.05n

.meas tran vdout1_2ck650 FIND v(dout1_2) AT=660.05n

.meas tran vdout1_3ck650 FIND v(dout1_3) AT=660.05n

.meas tran vdout1_4ck650 FIND v(dout1_4) AT=660.05n

.meas tran vdout1_5ck650 FIND v(dout1_5) AT=660.05n

.meas tran vdout1_6ck650 FIND v(dout1_6) AT=660.05n

.meas tran vdout1_7ck650 FIND v(dout1_7) AT=660.05n

.meas tran vdout1_8ck650 FIND v(dout1_8) AT=660.05n

.meas tran vdout1_9ck650 FIND v(dout1_9) AT=660.05n

.meas tran vdout1_10ck650 FIND v(dout1_10) AT=660.05n

.meas tran vdout1_11ck650 FIND v(dout1_11) AT=660.05n

.meas tran vdout1_0ck660 FIND v(dout1_0) AT=670.05n

.meas tran vdout1_1ck660 FIND v(dout1_1) AT=670.05n

.meas tran vdout1_2ck660 FIND v(dout1_2) AT=670.05n

.meas tran vdout1_3ck660 FIND v(dout1_3) AT=670.05n

.meas tran vdout1_4ck660 FIND v(dout1_4) AT=670.05n

.meas tran vdout1_5ck660 FIND v(dout1_5) AT=670.05n

.meas tran vdout1_6ck660 FIND v(dout1_6) AT=670.05n

.meas tran vdout1_7ck660 FIND v(dout1_7) AT=670.05n

.meas tran vdout1_8ck660 FIND v(dout1_8) AT=670.05n

.meas tran vdout1_9ck660 FIND v(dout1_9) AT=670.05n

.meas tran vdout1_10ck660 FIND v(dout1_10) AT=670.05n

.meas tran vdout1_11ck660 FIND v(dout1_11) AT=670.05n

.meas tran vdout1_0ck680 FIND v(dout1_0) AT=690.05n

.meas tran vdout1_1ck680 FIND v(dout1_1) AT=690.05n

.meas tran vdout1_2ck680 FIND v(dout1_2) AT=690.05n

.meas tran vdout1_3ck680 FIND v(dout1_3) AT=690.05n

.meas tran vdout1_4ck680 FIND v(dout1_4) AT=690.05n

.meas tran vdout1_5ck680 FIND v(dout1_5) AT=690.05n

.meas tran vdout1_6ck680 FIND v(dout1_6) AT=690.05n

.meas tran vdout1_7ck680 FIND v(dout1_7) AT=690.05n

.meas tran vdout1_8ck680 FIND v(dout1_8) AT=690.05n

.meas tran vdout1_9ck680 FIND v(dout1_9) AT=690.05n

.meas tran vdout1_10ck680 FIND v(dout1_10) AT=690.05n

.meas tran vdout1_11ck680 FIND v(dout1_11) AT=690.05n

.meas tran vdout1_0ck700 FIND v(dout1_0) AT=710.05n

.meas tran vdout1_1ck700 FIND v(dout1_1) AT=710.05n

.meas tran vdout1_2ck700 FIND v(dout1_2) AT=710.05n

.meas tran vdout1_3ck700 FIND v(dout1_3) AT=710.05n

.meas tran vdout1_4ck700 FIND v(dout1_4) AT=710.05n

.meas tran vdout1_5ck700 FIND v(dout1_5) AT=710.05n

.meas tran vdout1_6ck700 FIND v(dout1_6) AT=710.05n

.meas tran vdout1_7ck700 FIND v(dout1_7) AT=710.05n

.meas tran vdout1_8ck700 FIND v(dout1_8) AT=710.05n

.meas tran vdout1_9ck700 FIND v(dout1_9) AT=710.05n

.meas tran vdout1_10ck700 FIND v(dout1_10) AT=710.05n

.meas tran vdout1_11ck700 FIND v(dout1_11) AT=710.05n

.meas tran vdout1_0ck710 FIND v(dout1_0) AT=720.05n

.meas tran vdout1_1ck710 FIND v(dout1_1) AT=720.05n

.meas tran vdout1_2ck710 FIND v(dout1_2) AT=720.05n

.meas tran vdout1_3ck710 FIND v(dout1_3) AT=720.05n

.meas tran vdout1_4ck710 FIND v(dout1_4) AT=720.05n

.meas tran vdout1_5ck710 FIND v(dout1_5) AT=720.05n

.meas tran vdout1_6ck710 FIND v(dout1_6) AT=720.05n

.meas tran vdout1_7ck710 FIND v(dout1_7) AT=720.05n

.meas tran vdout1_8ck710 FIND v(dout1_8) AT=720.05n

.meas tran vdout1_9ck710 FIND v(dout1_9) AT=720.05n

.meas tran vdout1_10ck710 FIND v(dout1_10) AT=720.05n

.meas tran vdout1_11ck710 FIND v(dout1_11) AT=720.05n

.meas tran vdout1_0ck720 FIND v(dout1_0) AT=730.05n

.meas tran vdout1_1ck720 FIND v(dout1_1) AT=730.05n

.meas tran vdout1_2ck720 FIND v(dout1_2) AT=730.05n

.meas tran vdout1_3ck720 FIND v(dout1_3) AT=730.05n

.meas tran vdout1_4ck720 FIND v(dout1_4) AT=730.05n

.meas tran vdout1_5ck720 FIND v(dout1_5) AT=730.05n

.meas tran vdout1_6ck720 FIND v(dout1_6) AT=730.05n

.meas tran vdout1_7ck720 FIND v(dout1_7) AT=730.05n

.meas tran vdout1_8ck720 FIND v(dout1_8) AT=730.05n

.meas tran vdout1_9ck720 FIND v(dout1_9) AT=730.05n

.meas tran vdout1_10ck720 FIND v(dout1_10) AT=730.05n

.meas tran vdout1_11ck720 FIND v(dout1_11) AT=730.05n

.meas tran vdout1_0ck740 FIND v(dout1_0) AT=750.05n

.meas tran vdout1_1ck740 FIND v(dout1_1) AT=750.05n

.meas tran vdout1_2ck740 FIND v(dout1_2) AT=750.05n

.meas tran vdout1_3ck740 FIND v(dout1_3) AT=750.05n

.meas tran vdout1_4ck740 FIND v(dout1_4) AT=750.05n

.meas tran vdout1_5ck740 FIND v(dout1_5) AT=750.05n

.meas tran vdout1_6ck740 FIND v(dout1_6) AT=750.05n

.meas tran vdout1_7ck740 FIND v(dout1_7) AT=750.05n

.meas tran vdout1_8ck740 FIND v(dout1_8) AT=750.05n

.meas tran vdout1_9ck740 FIND v(dout1_9) AT=750.05n

.meas tran vdout1_10ck740 FIND v(dout1_10) AT=750.05n

.meas tran vdout1_11ck740 FIND v(dout1_11) AT=750.05n

.meas tran vdout1_0ck750 FIND v(dout1_0) AT=760.05n

.meas tran vdout1_1ck750 FIND v(dout1_1) AT=760.05n

.meas tran vdout1_2ck750 FIND v(dout1_2) AT=760.05n

.meas tran vdout1_3ck750 FIND v(dout1_3) AT=760.05n

.meas tran vdout1_4ck750 FIND v(dout1_4) AT=760.05n

.meas tran vdout1_5ck750 FIND v(dout1_5) AT=760.05n

.meas tran vdout1_6ck750 FIND v(dout1_6) AT=760.05n

.meas tran vdout1_7ck750 FIND v(dout1_7) AT=760.05n

.meas tran vdout1_8ck750 FIND v(dout1_8) AT=760.05n

.meas tran vdout1_9ck750 FIND v(dout1_9) AT=760.05n

.meas tran vdout1_10ck750 FIND v(dout1_10) AT=760.05n

.meas tran vdout1_11ck750 FIND v(dout1_11) AT=760.05n

.meas tran vdout1_0ck770 FIND v(dout1_0) AT=780.05n

.meas tran vdout1_1ck770 FIND v(dout1_1) AT=780.05n

.meas tran vdout1_2ck770 FIND v(dout1_2) AT=780.05n

.meas tran vdout1_3ck770 FIND v(dout1_3) AT=780.05n

.meas tran vdout1_4ck770 FIND v(dout1_4) AT=780.05n

.meas tran vdout1_5ck770 FIND v(dout1_5) AT=780.05n

.meas tran vdout1_6ck770 FIND v(dout1_6) AT=780.05n

.meas tran vdout1_7ck770 FIND v(dout1_7) AT=780.05n

.meas tran vdout1_8ck770 FIND v(dout1_8) AT=780.05n

.meas tran vdout1_9ck770 FIND v(dout1_9) AT=780.05n

.meas tran vdout1_10ck770 FIND v(dout1_10) AT=780.05n

.meas tran vdout1_11ck770 FIND v(dout1_11) AT=780.05n

.meas tran vdout1_0ck780 FIND v(dout1_0) AT=790.05n

.meas tran vdout1_1ck780 FIND v(dout1_1) AT=790.05n

.meas tran vdout1_2ck780 FIND v(dout1_2) AT=790.05n

.meas tran vdout1_3ck780 FIND v(dout1_3) AT=790.05n

.meas tran vdout1_4ck780 FIND v(dout1_4) AT=790.05n

.meas tran vdout1_5ck780 FIND v(dout1_5) AT=790.05n

.meas tran vdout1_6ck780 FIND v(dout1_6) AT=790.05n

.meas tran vdout1_7ck780 FIND v(dout1_7) AT=790.05n

.meas tran vdout1_8ck780 FIND v(dout1_8) AT=790.05n

.meas tran vdout1_9ck780 FIND v(dout1_9) AT=790.05n

.meas tran vdout1_10ck780 FIND v(dout1_10) AT=790.05n

.meas tran vdout1_11ck780 FIND v(dout1_11) AT=790.05n

.meas tran vdout1_0ck800 FIND v(dout1_0) AT=810.05n

.meas tran vdout1_1ck800 FIND v(dout1_1) AT=810.05n

.meas tran vdout1_2ck800 FIND v(dout1_2) AT=810.05n

.meas tran vdout1_3ck800 FIND v(dout1_3) AT=810.05n

.meas tran vdout1_4ck800 FIND v(dout1_4) AT=810.05n

.meas tran vdout1_5ck800 FIND v(dout1_5) AT=810.05n

.meas tran vdout1_6ck800 FIND v(dout1_6) AT=810.05n

.meas tran vdout1_7ck800 FIND v(dout1_7) AT=810.05n

.meas tran vdout1_8ck800 FIND v(dout1_8) AT=810.05n

.meas tran vdout1_9ck800 FIND v(dout1_9) AT=810.05n

.meas tran vdout1_10ck800 FIND v(dout1_10) AT=810.05n

.meas tran vdout1_11ck800 FIND v(dout1_11) AT=810.05n

.meas tran vdout1_0ck850 FIND v(dout1_0) AT=860.05n

.meas tran vdout1_1ck850 FIND v(dout1_1) AT=860.05n

.meas tran vdout1_2ck850 FIND v(dout1_2) AT=860.05n

.meas tran vdout1_3ck850 FIND v(dout1_3) AT=860.05n

.meas tran vdout1_4ck850 FIND v(dout1_4) AT=860.05n

.meas tran vdout1_5ck850 FIND v(dout1_5) AT=860.05n

.meas tran vdout1_6ck850 FIND v(dout1_6) AT=860.05n

.meas tran vdout1_7ck850 FIND v(dout1_7) AT=860.05n

.meas tran vdout1_8ck850 FIND v(dout1_8) AT=860.05n

.meas tran vdout1_9ck850 FIND v(dout1_9) AT=860.05n

.meas tran vdout1_10ck850 FIND v(dout1_10) AT=860.05n

.meas tran vdout1_11ck850 FIND v(dout1_11) AT=860.05n

.meas tran vdout1_0ck860 FIND v(dout1_0) AT=870.05n

.meas tran vdout1_1ck860 FIND v(dout1_1) AT=870.05n

.meas tran vdout1_2ck860 FIND v(dout1_2) AT=870.05n

.meas tran vdout1_3ck860 FIND v(dout1_3) AT=870.05n

.meas tran vdout1_4ck860 FIND v(dout1_4) AT=870.05n

.meas tran vdout1_5ck860 FIND v(dout1_5) AT=870.05n

.meas tran vdout1_6ck860 FIND v(dout1_6) AT=870.05n

.meas tran vdout1_7ck860 FIND v(dout1_7) AT=870.05n

.meas tran vdout1_8ck860 FIND v(dout1_8) AT=870.05n

.meas tran vdout1_9ck860 FIND v(dout1_9) AT=870.05n

.meas tran vdout1_10ck860 FIND v(dout1_10) AT=870.05n

.meas tran vdout1_11ck860 FIND v(dout1_11) AT=870.05n

.meas tran vdout1_0ck890 FIND v(dout1_0) AT=900.05n

.meas tran vdout1_1ck890 FIND v(dout1_1) AT=900.05n

.meas tran vdout1_2ck890 FIND v(dout1_2) AT=900.05n

.meas tran vdout1_3ck890 FIND v(dout1_3) AT=900.05n

.meas tran vdout1_4ck890 FIND v(dout1_4) AT=900.05n

.meas tran vdout1_5ck890 FIND v(dout1_5) AT=900.05n

.meas tran vdout1_6ck890 FIND v(dout1_6) AT=900.05n

.meas tran vdout1_7ck890 FIND v(dout1_7) AT=900.05n

.meas tran vdout1_8ck890 FIND v(dout1_8) AT=900.05n

.meas tran vdout1_9ck890 FIND v(dout1_9) AT=900.05n

.meas tran vdout1_10ck890 FIND v(dout1_10) AT=900.05n

.meas tran vdout1_11ck890 FIND v(dout1_11) AT=900.05n

.meas tran vdout1_0ck900 FIND v(dout1_0) AT=910.05n

.meas tran vdout1_1ck900 FIND v(dout1_1) AT=910.05n

.meas tran vdout1_2ck900 FIND v(dout1_2) AT=910.05n

.meas tran vdout1_3ck900 FIND v(dout1_3) AT=910.05n

.meas tran vdout1_4ck900 FIND v(dout1_4) AT=910.05n

.meas tran vdout1_5ck900 FIND v(dout1_5) AT=910.05n

.meas tran vdout1_6ck900 FIND v(dout1_6) AT=910.05n

.meas tran vdout1_7ck900 FIND v(dout1_7) AT=910.05n

.meas tran vdout1_8ck900 FIND v(dout1_8) AT=910.05n

.meas tran vdout1_9ck900 FIND v(dout1_9) AT=910.05n

.meas tran vdout1_10ck900 FIND v(dout1_10) AT=910.05n

.meas tran vdout1_11ck900 FIND v(dout1_11) AT=910.05n

.meas tran vdout1_0ck910 FIND v(dout1_0) AT=920.05n

.meas tran vdout1_1ck910 FIND v(dout1_1) AT=920.05n

.meas tran vdout1_2ck910 FIND v(dout1_2) AT=920.05n

.meas tran vdout1_3ck910 FIND v(dout1_3) AT=920.05n

.meas tran vdout1_4ck910 FIND v(dout1_4) AT=920.05n

.meas tran vdout1_5ck910 FIND v(dout1_5) AT=920.05n

.meas tran vdout1_6ck910 FIND v(dout1_6) AT=920.05n

.meas tran vdout1_7ck910 FIND v(dout1_7) AT=920.05n

.meas tran vdout1_8ck910 FIND v(dout1_8) AT=920.05n

.meas tran vdout1_9ck910 FIND v(dout1_9) AT=920.05n

.meas tran vdout1_10ck910 FIND v(dout1_10) AT=920.05n

.meas tran vdout1_11ck910 FIND v(dout1_11) AT=920.05n

.meas tran vdout1_0ck920 FIND v(dout1_0) AT=930.05n

.meas tran vdout1_1ck920 FIND v(dout1_1) AT=930.05n

.meas tran vdout1_2ck920 FIND v(dout1_2) AT=930.05n

.meas tran vdout1_3ck920 FIND v(dout1_3) AT=930.05n

.meas tran vdout1_4ck920 FIND v(dout1_4) AT=930.05n

.meas tran vdout1_5ck920 FIND v(dout1_5) AT=930.05n

.meas tran vdout1_6ck920 FIND v(dout1_6) AT=930.05n

.meas tran vdout1_7ck920 FIND v(dout1_7) AT=930.05n

.meas tran vdout1_8ck920 FIND v(dout1_8) AT=930.05n

.meas tran vdout1_9ck920 FIND v(dout1_9) AT=930.05n

.meas tran vdout1_10ck920 FIND v(dout1_10) AT=930.05n

.meas tran vdout1_11ck920 FIND v(dout1_11) AT=930.05n

.meas tran vdout1_0ck940 FIND v(dout1_0) AT=950.05n

.meas tran vdout1_1ck940 FIND v(dout1_1) AT=950.05n

.meas tran vdout1_2ck940 FIND v(dout1_2) AT=950.05n

.meas tran vdout1_3ck940 FIND v(dout1_3) AT=950.05n

.meas tran vdout1_4ck940 FIND v(dout1_4) AT=950.05n

.meas tran vdout1_5ck940 FIND v(dout1_5) AT=950.05n

.meas tran vdout1_6ck940 FIND v(dout1_6) AT=950.05n

.meas tran vdout1_7ck940 FIND v(dout1_7) AT=950.05n

.meas tran vdout1_8ck940 FIND v(dout1_8) AT=950.05n

.meas tran vdout1_9ck940 FIND v(dout1_9) AT=950.05n

.meas tran vdout1_10ck940 FIND v(dout1_10) AT=950.05n

.meas tran vdout1_11ck940 FIND v(dout1_11) AT=950.05n

.meas tran vdout1_0ck960 FIND v(dout1_0) AT=970.05n

.meas tran vdout1_1ck960 FIND v(dout1_1) AT=970.05n

.meas tran vdout1_2ck960 FIND v(dout1_2) AT=970.05n

.meas tran vdout1_3ck960 FIND v(dout1_3) AT=970.05n

.meas tran vdout1_4ck960 FIND v(dout1_4) AT=970.05n

.meas tran vdout1_5ck960 FIND v(dout1_5) AT=970.05n

.meas tran vdout1_6ck960 FIND v(dout1_6) AT=970.05n

.meas tran vdout1_7ck960 FIND v(dout1_7) AT=970.05n

.meas tran vdout1_8ck960 FIND v(dout1_8) AT=970.05n

.meas tran vdout1_9ck960 FIND v(dout1_9) AT=970.05n

.meas tran vdout1_10ck960 FIND v(dout1_10) AT=970.05n

.meas tran vdout1_11ck960 FIND v(dout1_11) AT=970.05n

.meas tran vdout1_0ck990 FIND v(dout1_0) AT=1000.05n

.meas tran vdout1_1ck990 FIND v(dout1_1) AT=1000.05n

.meas tran vdout1_2ck990 FIND v(dout1_2) AT=1000.05n

.meas tran vdout1_3ck990 FIND v(dout1_3) AT=1000.05n

.meas tran vdout1_4ck990 FIND v(dout1_4) AT=1000.05n

.meas tran vdout1_5ck990 FIND v(dout1_5) AT=1000.05n

.meas tran vdout1_6ck990 FIND v(dout1_6) AT=1000.05n

.meas tran vdout1_7ck990 FIND v(dout1_7) AT=1000.05n

.meas tran vdout1_8ck990 FIND v(dout1_8) AT=1000.05n

.meas tran vdout1_9ck990 FIND v(dout1_9) AT=1000.05n

.meas tran vdout1_10ck990 FIND v(dout1_10) AT=1000.05n

.meas tran vdout1_11ck990 FIND v(dout1_11) AT=1000.05n

.meas tran vdout1_0ck1010 FIND v(dout1_0) AT=1020.05n

.meas tran vdout1_1ck1010 FIND v(dout1_1) AT=1020.05n

.meas tran vdout1_2ck1010 FIND v(dout1_2) AT=1020.05n

.meas tran vdout1_3ck1010 FIND v(dout1_3) AT=1020.05n

.meas tran vdout1_4ck1010 FIND v(dout1_4) AT=1020.05n

.meas tran vdout1_5ck1010 FIND v(dout1_5) AT=1020.05n

.meas tran vdout1_6ck1010 FIND v(dout1_6) AT=1020.05n

.meas tran vdout1_7ck1010 FIND v(dout1_7) AT=1020.05n

.meas tran vdout1_8ck1010 FIND v(dout1_8) AT=1020.05n

.meas tran vdout1_9ck1010 FIND v(dout1_9) AT=1020.05n

.meas tran vdout1_10ck1010 FIND v(dout1_10) AT=1020.05n

.meas tran vdout1_11ck1010 FIND v(dout1_11) AT=1020.05n

.meas tran vdout1_0ck1020 FIND v(dout1_0) AT=1030.05n

.meas tran vdout1_1ck1020 FIND v(dout1_1) AT=1030.05n

.meas tran vdout1_2ck1020 FIND v(dout1_2) AT=1030.05n

.meas tran vdout1_3ck1020 FIND v(dout1_3) AT=1030.05n

.meas tran vdout1_4ck1020 FIND v(dout1_4) AT=1030.05n

.meas tran vdout1_5ck1020 FIND v(dout1_5) AT=1030.05n

.meas tran vdout1_6ck1020 FIND v(dout1_6) AT=1030.05n

.meas tran vdout1_7ck1020 FIND v(dout1_7) AT=1030.05n

.meas tran vdout1_8ck1020 FIND v(dout1_8) AT=1030.05n

.meas tran vdout1_9ck1020 FIND v(dout1_9) AT=1030.05n

.meas tran vdout1_10ck1020 FIND v(dout1_10) AT=1030.05n

.meas tran vdout1_11ck1020 FIND v(dout1_11) AT=1030.05n

.meas tran vdout1_0ck1030 FIND v(dout1_0) AT=1040.05n

.meas tran vdout1_1ck1030 FIND v(dout1_1) AT=1040.05n

.meas tran vdout1_2ck1030 FIND v(dout1_2) AT=1040.05n

.meas tran vdout1_3ck1030 FIND v(dout1_3) AT=1040.05n

.meas tran vdout1_4ck1030 FIND v(dout1_4) AT=1040.05n

.meas tran vdout1_5ck1030 FIND v(dout1_5) AT=1040.05n

.meas tran vdout1_6ck1030 FIND v(dout1_6) AT=1040.05n

.meas tran vdout1_7ck1030 FIND v(dout1_7) AT=1040.05n

.meas tran vdout1_8ck1030 FIND v(dout1_8) AT=1040.05n

.meas tran vdout1_9ck1030 FIND v(dout1_9) AT=1040.05n

.meas tran vdout1_10ck1030 FIND v(dout1_10) AT=1040.05n

.meas tran vdout1_11ck1030 FIND v(dout1_11) AT=1040.05n

.meas tran vdout1_0ck1080 FIND v(dout1_0) AT=1090.05n

.meas tran vdout1_1ck1080 FIND v(dout1_1) AT=1090.05n

.meas tran vdout1_2ck1080 FIND v(dout1_2) AT=1090.05n

.meas tran vdout1_3ck1080 FIND v(dout1_3) AT=1090.05n

.meas tran vdout1_4ck1080 FIND v(dout1_4) AT=1090.05n

.meas tran vdout1_5ck1080 FIND v(dout1_5) AT=1090.05n

.meas tran vdout1_6ck1080 FIND v(dout1_6) AT=1090.05n

.meas tran vdout1_7ck1080 FIND v(dout1_7) AT=1090.05n

.meas tran vdout1_8ck1080 FIND v(dout1_8) AT=1090.05n

.meas tran vdout1_9ck1080 FIND v(dout1_9) AT=1090.05n

.meas tran vdout1_10ck1080 FIND v(dout1_10) AT=1090.05n

.meas tran vdout1_11ck1080 FIND v(dout1_11) AT=1090.05n

.meas tran vdout1_0ck1120 FIND v(dout1_0) AT=1130.05n

.meas tran vdout1_1ck1120 FIND v(dout1_1) AT=1130.05n

.meas tran vdout1_2ck1120 FIND v(dout1_2) AT=1130.05n

.meas tran vdout1_3ck1120 FIND v(dout1_3) AT=1130.05n

.meas tran vdout1_4ck1120 FIND v(dout1_4) AT=1130.05n

.meas tran vdout1_5ck1120 FIND v(dout1_5) AT=1130.05n

.meas tran vdout1_6ck1120 FIND v(dout1_6) AT=1130.05n

.meas tran vdout1_7ck1120 FIND v(dout1_7) AT=1130.05n

.meas tran vdout1_8ck1120 FIND v(dout1_8) AT=1130.05n

.meas tran vdout1_9ck1120 FIND v(dout1_9) AT=1130.05n

.meas tran vdout1_10ck1120 FIND v(dout1_10) AT=1130.05n

.meas tran vdout1_11ck1120 FIND v(dout1_11) AT=1130.05n

.meas tran vdout1_0ck1150 FIND v(dout1_0) AT=1160.05n

.meas tran vdout1_1ck1150 FIND v(dout1_1) AT=1160.05n

.meas tran vdout1_2ck1150 FIND v(dout1_2) AT=1160.05n

.meas tran vdout1_3ck1150 FIND v(dout1_3) AT=1160.05n

.meas tran vdout1_4ck1150 FIND v(dout1_4) AT=1160.05n

.meas tran vdout1_5ck1150 FIND v(dout1_5) AT=1160.05n

.meas tran vdout1_6ck1150 FIND v(dout1_6) AT=1160.05n

.meas tran vdout1_7ck1150 FIND v(dout1_7) AT=1160.05n

.meas tran vdout1_8ck1150 FIND v(dout1_8) AT=1160.05n

.meas tran vdout1_9ck1150 FIND v(dout1_9) AT=1160.05n

.meas tran vdout1_10ck1150 FIND v(dout1_10) AT=1160.05n

.meas tran vdout1_11ck1150 FIND v(dout1_11) AT=1160.05n

.meas tran vdout1_0ck1160 FIND v(dout1_0) AT=1170.05n

.meas tran vdout1_1ck1160 FIND v(dout1_1) AT=1170.05n

.meas tran vdout1_2ck1160 FIND v(dout1_2) AT=1170.05n

.meas tran vdout1_3ck1160 FIND v(dout1_3) AT=1170.05n

.meas tran vdout1_4ck1160 FIND v(dout1_4) AT=1170.05n

.meas tran vdout1_5ck1160 FIND v(dout1_5) AT=1170.05n

.meas tran vdout1_6ck1160 FIND v(dout1_6) AT=1170.05n

.meas tran vdout1_7ck1160 FIND v(dout1_7) AT=1170.05n

.meas tran vdout1_8ck1160 FIND v(dout1_8) AT=1170.05n

.meas tran vdout1_9ck1160 FIND v(dout1_9) AT=1170.05n

.meas tran vdout1_10ck1160 FIND v(dout1_10) AT=1170.05n

.meas tran vdout1_11ck1160 FIND v(dout1_11) AT=1170.05n

.meas tran vdout1_0ck1190 FIND v(dout1_0) AT=1200.05n

.meas tran vdout1_1ck1190 FIND v(dout1_1) AT=1200.05n

.meas tran vdout1_2ck1190 FIND v(dout1_2) AT=1200.05n

.meas tran vdout1_3ck1190 FIND v(dout1_3) AT=1200.05n

.meas tran vdout1_4ck1190 FIND v(dout1_4) AT=1200.05n

.meas tran vdout1_5ck1190 FIND v(dout1_5) AT=1200.05n

.meas tran vdout1_6ck1190 FIND v(dout1_6) AT=1200.05n

.meas tran vdout1_7ck1190 FIND v(dout1_7) AT=1200.05n

.meas tran vdout1_8ck1190 FIND v(dout1_8) AT=1200.05n

.meas tran vdout1_9ck1190 FIND v(dout1_9) AT=1200.05n

.meas tran vdout1_10ck1190 FIND v(dout1_10) AT=1200.05n

.meas tran vdout1_11ck1190 FIND v(dout1_11) AT=1200.05n

.meas tran vdout1_0ck1200 FIND v(dout1_0) AT=1210.05n

.meas tran vdout1_1ck1200 FIND v(dout1_1) AT=1210.05n

.meas tran vdout1_2ck1200 FIND v(dout1_2) AT=1210.05n

.meas tran vdout1_3ck1200 FIND v(dout1_3) AT=1210.05n

.meas tran vdout1_4ck1200 FIND v(dout1_4) AT=1210.05n

.meas tran vdout1_5ck1200 FIND v(dout1_5) AT=1210.05n

.meas tran vdout1_6ck1200 FIND v(dout1_6) AT=1210.05n

.meas tran vdout1_7ck1200 FIND v(dout1_7) AT=1210.05n

.meas tran vdout1_8ck1200 FIND v(dout1_8) AT=1210.05n

.meas tran vdout1_9ck1200 FIND v(dout1_9) AT=1210.05n

.meas tran vdout1_10ck1200 FIND v(dout1_10) AT=1210.05n

.meas tran vdout1_11ck1200 FIND v(dout1_11) AT=1210.05n

.meas tran vdout1_0ck1240 FIND v(dout1_0) AT=1250.05n

.meas tran vdout1_1ck1240 FIND v(dout1_1) AT=1250.05n

.meas tran vdout1_2ck1240 FIND v(dout1_2) AT=1250.05n

.meas tran vdout1_3ck1240 FIND v(dout1_3) AT=1250.05n

.meas tran vdout1_4ck1240 FIND v(dout1_4) AT=1250.05n

.meas tran vdout1_5ck1240 FIND v(dout1_5) AT=1250.05n

.meas tran vdout1_6ck1240 FIND v(dout1_6) AT=1250.05n

.meas tran vdout1_7ck1240 FIND v(dout1_7) AT=1250.05n

.meas tran vdout1_8ck1240 FIND v(dout1_8) AT=1250.05n

.meas tran vdout1_9ck1240 FIND v(dout1_9) AT=1250.05n

.meas tran vdout1_10ck1240 FIND v(dout1_10) AT=1250.05n

.meas tran vdout1_11ck1240 FIND v(dout1_11) AT=1250.05n

.meas tran vdout1_0ck1270 FIND v(dout1_0) AT=1280.05n

.meas tran vdout1_1ck1270 FIND v(dout1_1) AT=1280.05n

.meas tran vdout1_2ck1270 FIND v(dout1_2) AT=1280.05n

.meas tran vdout1_3ck1270 FIND v(dout1_3) AT=1280.05n

.meas tran vdout1_4ck1270 FIND v(dout1_4) AT=1280.05n

.meas tran vdout1_5ck1270 FIND v(dout1_5) AT=1280.05n

.meas tran vdout1_6ck1270 FIND v(dout1_6) AT=1280.05n

.meas tran vdout1_7ck1270 FIND v(dout1_7) AT=1280.05n

.meas tran vdout1_8ck1270 FIND v(dout1_8) AT=1280.05n

.meas tran vdout1_9ck1270 FIND v(dout1_9) AT=1280.05n

.meas tran vdout1_10ck1270 FIND v(dout1_10) AT=1280.05n

.meas tran vdout1_11ck1270 FIND v(dout1_11) AT=1280.05n

.meas tran vdout1_0ck1290 FIND v(dout1_0) AT=1300.05n

.meas tran vdout1_1ck1290 FIND v(dout1_1) AT=1300.05n

.meas tran vdout1_2ck1290 FIND v(dout1_2) AT=1300.05n

.meas tran vdout1_3ck1290 FIND v(dout1_3) AT=1300.05n

.meas tran vdout1_4ck1290 FIND v(dout1_4) AT=1300.05n

.meas tran vdout1_5ck1290 FIND v(dout1_5) AT=1300.05n

.meas tran vdout1_6ck1290 FIND v(dout1_6) AT=1300.05n

.meas tran vdout1_7ck1290 FIND v(dout1_7) AT=1300.05n

.meas tran vdout1_8ck1290 FIND v(dout1_8) AT=1300.05n

.meas tran vdout1_9ck1290 FIND v(dout1_9) AT=1300.05n

.meas tran vdout1_10ck1290 FIND v(dout1_10) AT=1300.05n

.meas tran vdout1_11ck1290 FIND v(dout1_11) AT=1300.05n

.meas tran vdout1_0ck1330 FIND v(dout1_0) AT=1340.05n

.meas tran vdout1_1ck1330 FIND v(dout1_1) AT=1340.05n

.meas tran vdout1_2ck1330 FIND v(dout1_2) AT=1340.05n

.meas tran vdout1_3ck1330 FIND v(dout1_3) AT=1340.05n

.meas tran vdout1_4ck1330 FIND v(dout1_4) AT=1340.05n

.meas tran vdout1_5ck1330 FIND v(dout1_5) AT=1340.05n

.meas tran vdout1_6ck1330 FIND v(dout1_6) AT=1340.05n

.meas tran vdout1_7ck1330 FIND v(dout1_7) AT=1340.05n

.meas tran vdout1_8ck1330 FIND v(dout1_8) AT=1340.05n

.meas tran vdout1_9ck1330 FIND v(dout1_9) AT=1340.05n

.meas tran vdout1_10ck1330 FIND v(dout1_10) AT=1340.05n

.meas tran vdout1_11ck1330 FIND v(dout1_11) AT=1340.05n

.meas tran vdout1_0ck1420 FIND v(dout1_0) AT=1430.05n

.meas tran vdout1_1ck1420 FIND v(dout1_1) AT=1430.05n

.meas tran vdout1_2ck1420 FIND v(dout1_2) AT=1430.05n

.meas tran vdout1_3ck1420 FIND v(dout1_3) AT=1430.05n

.meas tran vdout1_4ck1420 FIND v(dout1_4) AT=1430.05n

.meas tran vdout1_5ck1420 FIND v(dout1_5) AT=1430.05n

.meas tran vdout1_6ck1420 FIND v(dout1_6) AT=1430.05n

.meas tran vdout1_7ck1420 FIND v(dout1_7) AT=1430.05n

.meas tran vdout1_8ck1420 FIND v(dout1_8) AT=1430.05n

.meas tran vdout1_9ck1420 FIND v(dout1_9) AT=1430.05n

.meas tran vdout1_10ck1420 FIND v(dout1_10) AT=1430.05n

.meas tran vdout1_11ck1420 FIND v(dout1_11) AT=1430.05n

.meas tran vdout1_0ck1430 FIND v(dout1_0) AT=1440.05n

.meas tran vdout1_1ck1430 FIND v(dout1_1) AT=1440.05n

.meas tran vdout1_2ck1430 FIND v(dout1_2) AT=1440.05n

.meas tran vdout1_3ck1430 FIND v(dout1_3) AT=1440.05n

.meas tran vdout1_4ck1430 FIND v(dout1_4) AT=1440.05n

.meas tran vdout1_5ck1430 FIND v(dout1_5) AT=1440.05n

.meas tran vdout1_6ck1430 FIND v(dout1_6) AT=1440.05n

.meas tran vdout1_7ck1430 FIND v(dout1_7) AT=1440.05n

.meas tran vdout1_8ck1430 FIND v(dout1_8) AT=1440.05n

.meas tran vdout1_9ck1430 FIND v(dout1_9) AT=1440.05n

.meas tran vdout1_10ck1430 FIND v(dout1_10) AT=1440.05n

.meas tran vdout1_11ck1430 FIND v(dout1_11) AT=1440.05n

.meas tran vdout1_0ck1440 FIND v(dout1_0) AT=1450.05n

.meas tran vdout1_1ck1440 FIND v(dout1_1) AT=1450.05n

.meas tran vdout1_2ck1440 FIND v(dout1_2) AT=1450.05n

.meas tran vdout1_3ck1440 FIND v(dout1_3) AT=1450.05n

.meas tran vdout1_4ck1440 FIND v(dout1_4) AT=1450.05n

.meas tran vdout1_5ck1440 FIND v(dout1_5) AT=1450.05n

.meas tran vdout1_6ck1440 FIND v(dout1_6) AT=1450.05n

.meas tran vdout1_7ck1440 FIND v(dout1_7) AT=1450.05n

.meas tran vdout1_8ck1440 FIND v(dout1_8) AT=1450.05n

.meas tran vdout1_9ck1440 FIND v(dout1_9) AT=1450.05n

.meas tran vdout1_10ck1440 FIND v(dout1_10) AT=1450.05n

.meas tran vdout1_11ck1440 FIND v(dout1_11) AT=1450.05n

.meas tran vdout1_0ck1450 FIND v(dout1_0) AT=1460.05n

.meas tran vdout1_1ck1450 FIND v(dout1_1) AT=1460.05n

.meas tran vdout1_2ck1450 FIND v(dout1_2) AT=1460.05n

.meas tran vdout1_3ck1450 FIND v(dout1_3) AT=1460.05n

.meas tran vdout1_4ck1450 FIND v(dout1_4) AT=1460.05n

.meas tran vdout1_5ck1450 FIND v(dout1_5) AT=1460.05n

.meas tran vdout1_6ck1450 FIND v(dout1_6) AT=1460.05n

.meas tran vdout1_7ck1450 FIND v(dout1_7) AT=1460.05n

.meas tran vdout1_8ck1450 FIND v(dout1_8) AT=1460.05n

.meas tran vdout1_9ck1450 FIND v(dout1_9) AT=1460.05n

.meas tran vdout1_10ck1450 FIND v(dout1_10) AT=1460.05n

.meas tran vdout1_11ck1450 FIND v(dout1_11) AT=1460.05n

.meas tran vdout1_0ck1460 FIND v(dout1_0) AT=1470.05n

.meas tran vdout1_1ck1460 FIND v(dout1_1) AT=1470.05n

.meas tran vdout1_2ck1460 FIND v(dout1_2) AT=1470.05n

.meas tran vdout1_3ck1460 FIND v(dout1_3) AT=1470.05n

.meas tran vdout1_4ck1460 FIND v(dout1_4) AT=1470.05n

.meas tran vdout1_5ck1460 FIND v(dout1_5) AT=1470.05n

.meas tran vdout1_6ck1460 FIND v(dout1_6) AT=1470.05n

.meas tran vdout1_7ck1460 FIND v(dout1_7) AT=1470.05n

.meas tran vdout1_8ck1460 FIND v(dout1_8) AT=1470.05n

.meas tran vdout1_9ck1460 FIND v(dout1_9) AT=1470.05n

.meas tran vdout1_10ck1460 FIND v(dout1_10) AT=1470.05n

.meas tran vdout1_11ck1460 FIND v(dout1_11) AT=1470.05n

.meas tran vdout1_0ck1470 FIND v(dout1_0) AT=1480.05n

.meas tran vdout1_1ck1470 FIND v(dout1_1) AT=1480.05n

.meas tran vdout1_2ck1470 FIND v(dout1_2) AT=1480.05n

.meas tran vdout1_3ck1470 FIND v(dout1_3) AT=1480.05n

.meas tran vdout1_4ck1470 FIND v(dout1_4) AT=1480.05n

.meas tran vdout1_5ck1470 FIND v(dout1_5) AT=1480.05n

.meas tran vdout1_6ck1470 FIND v(dout1_6) AT=1480.05n

.meas tran vdout1_7ck1470 FIND v(dout1_7) AT=1480.05n

.meas tran vdout1_8ck1470 FIND v(dout1_8) AT=1480.05n

.meas tran vdout1_9ck1470 FIND v(dout1_9) AT=1480.05n

.meas tran vdout1_10ck1470 FIND v(dout1_10) AT=1480.05n

.meas tran vdout1_11ck1470 FIND v(dout1_11) AT=1480.05n

.meas tran vdout1_0ck1480 FIND v(dout1_0) AT=1490.05n

.meas tran vdout1_1ck1480 FIND v(dout1_1) AT=1490.05n

.meas tran vdout1_2ck1480 FIND v(dout1_2) AT=1490.05n

.meas tran vdout1_3ck1480 FIND v(dout1_3) AT=1490.05n

.meas tran vdout1_4ck1480 FIND v(dout1_4) AT=1490.05n

.meas tran vdout1_5ck1480 FIND v(dout1_5) AT=1490.05n

.meas tran vdout1_6ck1480 FIND v(dout1_6) AT=1490.05n

.meas tran vdout1_7ck1480 FIND v(dout1_7) AT=1490.05n

.meas tran vdout1_8ck1480 FIND v(dout1_8) AT=1490.05n

.meas tran vdout1_9ck1480 FIND v(dout1_9) AT=1490.05n

.meas tran vdout1_10ck1480 FIND v(dout1_10) AT=1490.05n

.meas tran vdout1_11ck1480 FIND v(dout1_11) AT=1490.05n

.meas tran vdout1_0ck1490 FIND v(dout1_0) AT=1500.05n

.meas tran vdout1_1ck1490 FIND v(dout1_1) AT=1500.05n

.meas tran vdout1_2ck1490 FIND v(dout1_2) AT=1500.05n

.meas tran vdout1_3ck1490 FIND v(dout1_3) AT=1500.05n

.meas tran vdout1_4ck1490 FIND v(dout1_4) AT=1500.05n

.meas tran vdout1_5ck1490 FIND v(dout1_5) AT=1500.05n

.meas tran vdout1_6ck1490 FIND v(dout1_6) AT=1500.05n

.meas tran vdout1_7ck1490 FIND v(dout1_7) AT=1500.05n

.meas tran vdout1_8ck1490 FIND v(dout1_8) AT=1500.05n

.meas tran vdout1_9ck1490 FIND v(dout1_9) AT=1500.05n

.meas tran vdout1_10ck1490 FIND v(dout1_10) AT=1500.05n

.meas tran vdout1_11ck1490 FIND v(dout1_11) AT=1500.05n

.meas tran vdout1_0ck1510 FIND v(dout1_0) AT=1520.05n

.meas tran vdout1_1ck1510 FIND v(dout1_1) AT=1520.05n

.meas tran vdout1_2ck1510 FIND v(dout1_2) AT=1520.05n

.meas tran vdout1_3ck1510 FIND v(dout1_3) AT=1520.05n

.meas tran vdout1_4ck1510 FIND v(dout1_4) AT=1520.05n

.meas tran vdout1_5ck1510 FIND v(dout1_5) AT=1520.05n

.meas tran vdout1_6ck1510 FIND v(dout1_6) AT=1520.05n

.meas tran vdout1_7ck1510 FIND v(dout1_7) AT=1520.05n

.meas tran vdout1_8ck1510 FIND v(dout1_8) AT=1520.05n

.meas tran vdout1_9ck1510 FIND v(dout1_9) AT=1520.05n

.meas tran vdout1_10ck1510 FIND v(dout1_10) AT=1520.05n

.meas tran vdout1_11ck1510 FIND v(dout1_11) AT=1520.05n

.meas tran vdout1_0ck1530 FIND v(dout1_0) AT=1540.05n

.meas tran vdout1_1ck1530 FIND v(dout1_1) AT=1540.05n

.meas tran vdout1_2ck1530 FIND v(dout1_2) AT=1540.05n

.meas tran vdout1_3ck1530 FIND v(dout1_3) AT=1540.05n

.meas tran vdout1_4ck1530 FIND v(dout1_4) AT=1540.05n

.meas tran vdout1_5ck1530 FIND v(dout1_5) AT=1540.05n

.meas tran vdout1_6ck1530 FIND v(dout1_6) AT=1540.05n

.meas tran vdout1_7ck1530 FIND v(dout1_7) AT=1540.05n

.meas tran vdout1_8ck1530 FIND v(dout1_8) AT=1540.05n

.meas tran vdout1_9ck1530 FIND v(dout1_9) AT=1540.05n

.meas tran vdout1_10ck1530 FIND v(dout1_10) AT=1540.05n

.meas tran vdout1_11ck1530 FIND v(dout1_11) AT=1540.05n

.meas tran vdout1_0ck1550 FIND v(dout1_0) AT=1560.05n

.meas tran vdout1_1ck1550 FIND v(dout1_1) AT=1560.05n

.meas tran vdout1_2ck1550 FIND v(dout1_2) AT=1560.05n

.meas tran vdout1_3ck1550 FIND v(dout1_3) AT=1560.05n

.meas tran vdout1_4ck1550 FIND v(dout1_4) AT=1560.05n

.meas tran vdout1_5ck1550 FIND v(dout1_5) AT=1560.05n

.meas tran vdout1_6ck1550 FIND v(dout1_6) AT=1560.05n

.meas tran vdout1_7ck1550 FIND v(dout1_7) AT=1560.05n

.meas tran vdout1_8ck1550 FIND v(dout1_8) AT=1560.05n

.meas tran vdout1_9ck1550 FIND v(dout1_9) AT=1560.05n

.meas tran vdout1_10ck1550 FIND v(dout1_10) AT=1560.05n

.meas tran vdout1_11ck1550 FIND v(dout1_11) AT=1560.05n

.meas tran vdout1_0ck1610 FIND v(dout1_0) AT=1620.05n

.meas tran vdout1_1ck1610 FIND v(dout1_1) AT=1620.05n

.meas tran vdout1_2ck1610 FIND v(dout1_2) AT=1620.05n

.meas tran vdout1_3ck1610 FIND v(dout1_3) AT=1620.05n

.meas tran vdout1_4ck1610 FIND v(dout1_4) AT=1620.05n

.meas tran vdout1_5ck1610 FIND v(dout1_5) AT=1620.05n

.meas tran vdout1_6ck1610 FIND v(dout1_6) AT=1620.05n

.meas tran vdout1_7ck1610 FIND v(dout1_7) AT=1620.05n

.meas tran vdout1_8ck1610 FIND v(dout1_8) AT=1620.05n

.meas tran vdout1_9ck1610 FIND v(dout1_9) AT=1620.05n

.meas tran vdout1_10ck1610 FIND v(dout1_10) AT=1620.05n

.meas tran vdout1_11ck1610 FIND v(dout1_11) AT=1620.05n

.meas tran vdout1_0ck1630 FIND v(dout1_0) AT=1640.05n

.meas tran vdout1_1ck1630 FIND v(dout1_1) AT=1640.05n

.meas tran vdout1_2ck1630 FIND v(dout1_2) AT=1640.05n

.meas tran vdout1_3ck1630 FIND v(dout1_3) AT=1640.05n

.meas tran vdout1_4ck1630 FIND v(dout1_4) AT=1640.05n

.meas tran vdout1_5ck1630 FIND v(dout1_5) AT=1640.05n

.meas tran vdout1_6ck1630 FIND v(dout1_6) AT=1640.05n

.meas tran vdout1_7ck1630 FIND v(dout1_7) AT=1640.05n

.meas tran vdout1_8ck1630 FIND v(dout1_8) AT=1640.05n

.meas tran vdout1_9ck1630 FIND v(dout1_9) AT=1640.05n

.meas tran vdout1_10ck1630 FIND v(dout1_10) AT=1640.05n

.meas tran vdout1_11ck1630 FIND v(dout1_11) AT=1640.05n

.meas tran vdout1_0ck1650 FIND v(dout1_0) AT=1660.05n

.meas tran vdout1_1ck1650 FIND v(dout1_1) AT=1660.05n

.meas tran vdout1_2ck1650 FIND v(dout1_2) AT=1660.05n

.meas tran vdout1_3ck1650 FIND v(dout1_3) AT=1660.05n

.meas tran vdout1_4ck1650 FIND v(dout1_4) AT=1660.05n

.meas tran vdout1_5ck1650 FIND v(dout1_5) AT=1660.05n

.meas tran vdout1_6ck1650 FIND v(dout1_6) AT=1660.05n

.meas tran vdout1_7ck1650 FIND v(dout1_7) AT=1660.05n

.meas tran vdout1_8ck1650 FIND v(dout1_8) AT=1660.05n

.meas tran vdout1_9ck1650 FIND v(dout1_9) AT=1660.05n

.meas tran vdout1_10ck1650 FIND v(dout1_10) AT=1660.05n

.meas tran vdout1_11ck1650 FIND v(dout1_11) AT=1660.05n

.meas tran vdout1_0ck1660 FIND v(dout1_0) AT=1670.05n

.meas tran vdout1_1ck1660 FIND v(dout1_1) AT=1670.05n

.meas tran vdout1_2ck1660 FIND v(dout1_2) AT=1670.05n

.meas tran vdout1_3ck1660 FIND v(dout1_3) AT=1670.05n

.meas tran vdout1_4ck1660 FIND v(dout1_4) AT=1670.05n

.meas tran vdout1_5ck1660 FIND v(dout1_5) AT=1670.05n

.meas tran vdout1_6ck1660 FIND v(dout1_6) AT=1670.05n

.meas tran vdout1_7ck1660 FIND v(dout1_7) AT=1670.05n

.meas tran vdout1_8ck1660 FIND v(dout1_8) AT=1670.05n

.meas tran vdout1_9ck1660 FIND v(dout1_9) AT=1670.05n

.meas tran vdout1_10ck1660 FIND v(dout1_10) AT=1670.05n

.meas tran vdout1_11ck1660 FIND v(dout1_11) AT=1670.05n

.meas tran vdout1_0ck1680 FIND v(dout1_0) AT=1690.05n

.meas tran vdout1_1ck1680 FIND v(dout1_1) AT=1690.05n

.meas tran vdout1_2ck1680 FIND v(dout1_2) AT=1690.05n

.meas tran vdout1_3ck1680 FIND v(dout1_3) AT=1690.05n

.meas tran vdout1_4ck1680 FIND v(dout1_4) AT=1690.05n

.meas tran vdout1_5ck1680 FIND v(dout1_5) AT=1690.05n

.meas tran vdout1_6ck1680 FIND v(dout1_6) AT=1690.05n

.meas tran vdout1_7ck1680 FIND v(dout1_7) AT=1690.05n

.meas tran vdout1_8ck1680 FIND v(dout1_8) AT=1690.05n

.meas tran vdout1_9ck1680 FIND v(dout1_9) AT=1690.05n

.meas tran vdout1_10ck1680 FIND v(dout1_10) AT=1690.05n

.meas tran vdout1_11ck1680 FIND v(dout1_11) AT=1690.05n

.meas tran vdout1_0ck1710 FIND v(dout1_0) AT=1720.05n

.meas tran vdout1_1ck1710 FIND v(dout1_1) AT=1720.05n

.meas tran vdout1_2ck1710 FIND v(dout1_2) AT=1720.05n

.meas tran vdout1_3ck1710 FIND v(dout1_3) AT=1720.05n

.meas tran vdout1_4ck1710 FIND v(dout1_4) AT=1720.05n

.meas tran vdout1_5ck1710 FIND v(dout1_5) AT=1720.05n

.meas tran vdout1_6ck1710 FIND v(dout1_6) AT=1720.05n

.meas tran vdout1_7ck1710 FIND v(dout1_7) AT=1720.05n

.meas tran vdout1_8ck1710 FIND v(dout1_8) AT=1720.05n

.meas tran vdout1_9ck1710 FIND v(dout1_9) AT=1720.05n

.meas tran vdout1_10ck1710 FIND v(dout1_10) AT=1720.05n

.meas tran vdout1_11ck1710 FIND v(dout1_11) AT=1720.05n

.meas tran vdout1_0ck1720 FIND v(dout1_0) AT=1730.05n

.meas tran vdout1_1ck1720 FIND v(dout1_1) AT=1730.05n

.meas tran vdout1_2ck1720 FIND v(dout1_2) AT=1730.05n

.meas tran vdout1_3ck1720 FIND v(dout1_3) AT=1730.05n

.meas tran vdout1_4ck1720 FIND v(dout1_4) AT=1730.05n

.meas tran vdout1_5ck1720 FIND v(dout1_5) AT=1730.05n

.meas tran vdout1_6ck1720 FIND v(dout1_6) AT=1730.05n

.meas tran vdout1_7ck1720 FIND v(dout1_7) AT=1730.05n

.meas tran vdout1_8ck1720 FIND v(dout1_8) AT=1730.05n

.meas tran vdout1_9ck1720 FIND v(dout1_9) AT=1730.05n

.meas tran vdout1_10ck1720 FIND v(dout1_10) AT=1730.05n

.meas tran vdout1_11ck1720 FIND v(dout1_11) AT=1730.05n

.meas tran vdout1_0ck1740 FIND v(dout1_0) AT=1750.05n

.meas tran vdout1_1ck1740 FIND v(dout1_1) AT=1750.05n

.meas tran vdout1_2ck1740 FIND v(dout1_2) AT=1750.05n

.meas tran vdout1_3ck1740 FIND v(dout1_3) AT=1750.05n

.meas tran vdout1_4ck1740 FIND v(dout1_4) AT=1750.05n

.meas tran vdout1_5ck1740 FIND v(dout1_5) AT=1750.05n

.meas tran vdout1_6ck1740 FIND v(dout1_6) AT=1750.05n

.meas tran vdout1_7ck1740 FIND v(dout1_7) AT=1750.05n

.meas tran vdout1_8ck1740 FIND v(dout1_8) AT=1750.05n

.meas tran vdout1_9ck1740 FIND v(dout1_9) AT=1750.05n

.meas tran vdout1_10ck1740 FIND v(dout1_10) AT=1750.05n

.meas tran vdout1_11ck1740 FIND v(dout1_11) AT=1750.05n

.meas tran vdout1_0ck1790 FIND v(dout1_0) AT=1800.05n

.meas tran vdout1_1ck1790 FIND v(dout1_1) AT=1800.05n

.meas tran vdout1_2ck1790 FIND v(dout1_2) AT=1800.05n

.meas tran vdout1_3ck1790 FIND v(dout1_3) AT=1800.05n

.meas tran vdout1_4ck1790 FIND v(dout1_4) AT=1800.05n

.meas tran vdout1_5ck1790 FIND v(dout1_5) AT=1800.05n

.meas tran vdout1_6ck1790 FIND v(dout1_6) AT=1800.05n

.meas tran vdout1_7ck1790 FIND v(dout1_7) AT=1800.05n

.meas tran vdout1_8ck1790 FIND v(dout1_8) AT=1800.05n

.meas tran vdout1_9ck1790 FIND v(dout1_9) AT=1800.05n

.meas tran vdout1_10ck1790 FIND v(dout1_10) AT=1800.05n

.meas tran vdout1_11ck1790 FIND v(dout1_11) AT=1800.05n

.meas tran vdout1_0ck1820 FIND v(dout1_0) AT=1830.05n

.meas tran vdout1_1ck1820 FIND v(dout1_1) AT=1830.05n

.meas tran vdout1_2ck1820 FIND v(dout1_2) AT=1830.05n

.meas tran vdout1_3ck1820 FIND v(dout1_3) AT=1830.05n

.meas tran vdout1_4ck1820 FIND v(dout1_4) AT=1830.05n

.meas tran vdout1_5ck1820 FIND v(dout1_5) AT=1830.05n

.meas tran vdout1_6ck1820 FIND v(dout1_6) AT=1830.05n

.meas tran vdout1_7ck1820 FIND v(dout1_7) AT=1830.05n

.meas tran vdout1_8ck1820 FIND v(dout1_8) AT=1830.05n

.meas tran vdout1_9ck1820 FIND v(dout1_9) AT=1830.05n

.meas tran vdout1_10ck1820 FIND v(dout1_10) AT=1830.05n

.meas tran vdout1_11ck1820 FIND v(dout1_11) AT=1830.05n

.meas tran vdout1_0ck1850 FIND v(dout1_0) AT=1860.05n

.meas tran vdout1_1ck1850 FIND v(dout1_1) AT=1860.05n

.meas tran vdout1_2ck1850 FIND v(dout1_2) AT=1860.05n

.meas tran vdout1_3ck1850 FIND v(dout1_3) AT=1860.05n

.meas tran vdout1_4ck1850 FIND v(dout1_4) AT=1860.05n

.meas tran vdout1_5ck1850 FIND v(dout1_5) AT=1860.05n

.meas tran vdout1_6ck1850 FIND v(dout1_6) AT=1860.05n

.meas tran vdout1_7ck1850 FIND v(dout1_7) AT=1860.05n

.meas tran vdout1_8ck1850 FIND v(dout1_8) AT=1860.05n

.meas tran vdout1_9ck1850 FIND v(dout1_9) AT=1860.05n

.meas tran vdout1_10ck1850 FIND v(dout1_10) AT=1860.05n

.meas tran vdout1_11ck1850 FIND v(dout1_11) AT=1860.05n

.meas tran vdout1_0ck1860 FIND v(dout1_0) AT=1870.05n

.meas tran vdout1_1ck1860 FIND v(dout1_1) AT=1870.05n

.meas tran vdout1_2ck1860 FIND v(dout1_2) AT=1870.05n

.meas tran vdout1_3ck1860 FIND v(dout1_3) AT=1870.05n

.meas tran vdout1_4ck1860 FIND v(dout1_4) AT=1870.05n

.meas tran vdout1_5ck1860 FIND v(dout1_5) AT=1870.05n

.meas tran vdout1_6ck1860 FIND v(dout1_6) AT=1870.05n

.meas tran vdout1_7ck1860 FIND v(dout1_7) AT=1870.05n

.meas tran vdout1_8ck1860 FIND v(dout1_8) AT=1870.05n

.meas tran vdout1_9ck1860 FIND v(dout1_9) AT=1870.05n

.meas tran vdout1_10ck1860 FIND v(dout1_10) AT=1870.05n

.meas tran vdout1_11ck1860 FIND v(dout1_11) AT=1870.05n

.meas tran vdout1_0ck1870 FIND v(dout1_0) AT=1880.05n

.meas tran vdout1_1ck1870 FIND v(dout1_1) AT=1880.05n

.meas tran vdout1_2ck1870 FIND v(dout1_2) AT=1880.05n

.meas tran vdout1_3ck1870 FIND v(dout1_3) AT=1880.05n

.meas tran vdout1_4ck1870 FIND v(dout1_4) AT=1880.05n

.meas tran vdout1_5ck1870 FIND v(dout1_5) AT=1880.05n

.meas tran vdout1_6ck1870 FIND v(dout1_6) AT=1880.05n

.meas tran vdout1_7ck1870 FIND v(dout1_7) AT=1880.05n

.meas tran vdout1_8ck1870 FIND v(dout1_8) AT=1880.05n

.meas tran vdout1_9ck1870 FIND v(dout1_9) AT=1880.05n

.meas tran vdout1_10ck1870 FIND v(dout1_10) AT=1880.05n

.meas tran vdout1_11ck1870 FIND v(dout1_11) AT=1880.05n

.meas tran vdout1_0ck1880 FIND v(dout1_0) AT=1890.05n

.meas tran vdout1_1ck1880 FIND v(dout1_1) AT=1890.05n

.meas tran vdout1_2ck1880 FIND v(dout1_2) AT=1890.05n

.meas tran vdout1_3ck1880 FIND v(dout1_3) AT=1890.05n

.meas tran vdout1_4ck1880 FIND v(dout1_4) AT=1890.05n

.meas tran vdout1_5ck1880 FIND v(dout1_5) AT=1890.05n

.meas tran vdout1_6ck1880 FIND v(dout1_6) AT=1890.05n

.meas tran vdout1_7ck1880 FIND v(dout1_7) AT=1890.05n

.meas tran vdout1_8ck1880 FIND v(dout1_8) AT=1890.05n

.meas tran vdout1_9ck1880 FIND v(dout1_9) AT=1890.05n

.meas tran vdout1_10ck1880 FIND v(dout1_10) AT=1890.05n

.meas tran vdout1_11ck1880 FIND v(dout1_11) AT=1890.05n

.meas tran vdout1_0ck1890 FIND v(dout1_0) AT=1900.05n

.meas tran vdout1_1ck1890 FIND v(dout1_1) AT=1900.05n

.meas tran vdout1_2ck1890 FIND v(dout1_2) AT=1900.05n

.meas tran vdout1_3ck1890 FIND v(dout1_3) AT=1900.05n

.meas tran vdout1_4ck1890 FIND v(dout1_4) AT=1900.05n

.meas tran vdout1_5ck1890 FIND v(dout1_5) AT=1900.05n

.meas tran vdout1_6ck1890 FIND v(dout1_6) AT=1900.05n

.meas tran vdout1_7ck1890 FIND v(dout1_7) AT=1900.05n

.meas tran vdout1_8ck1890 FIND v(dout1_8) AT=1900.05n

.meas tran vdout1_9ck1890 FIND v(dout1_9) AT=1900.05n

.meas tran vdout1_10ck1890 FIND v(dout1_10) AT=1900.05n

.meas tran vdout1_11ck1890 FIND v(dout1_11) AT=1900.05n

.meas tran vdout1_0ck1910 FIND v(dout1_0) AT=1920.05n

.meas tran vdout1_1ck1910 FIND v(dout1_1) AT=1920.05n

.meas tran vdout1_2ck1910 FIND v(dout1_2) AT=1920.05n

.meas tran vdout1_3ck1910 FIND v(dout1_3) AT=1920.05n

.meas tran vdout1_4ck1910 FIND v(dout1_4) AT=1920.05n

.meas tran vdout1_5ck1910 FIND v(dout1_5) AT=1920.05n

.meas tran vdout1_6ck1910 FIND v(dout1_6) AT=1920.05n

.meas tran vdout1_7ck1910 FIND v(dout1_7) AT=1920.05n

.meas tran vdout1_8ck1910 FIND v(dout1_8) AT=1920.05n

.meas tran vdout1_9ck1910 FIND v(dout1_9) AT=1920.05n

.meas tran vdout1_10ck1910 FIND v(dout1_10) AT=1920.05n

.meas tran vdout1_11ck1910 FIND v(dout1_11) AT=1920.05n

.meas tran vdout1_0ck1920 FIND v(dout1_0) AT=1930.05n

.meas tran vdout1_1ck1920 FIND v(dout1_1) AT=1930.05n

.meas tran vdout1_2ck1920 FIND v(dout1_2) AT=1930.05n

.meas tran vdout1_3ck1920 FIND v(dout1_3) AT=1930.05n

.meas tran vdout1_4ck1920 FIND v(dout1_4) AT=1930.05n

.meas tran vdout1_5ck1920 FIND v(dout1_5) AT=1930.05n

.meas tran vdout1_6ck1920 FIND v(dout1_6) AT=1930.05n

.meas tran vdout1_7ck1920 FIND v(dout1_7) AT=1930.05n

.meas tran vdout1_8ck1920 FIND v(dout1_8) AT=1930.05n

.meas tran vdout1_9ck1920 FIND v(dout1_9) AT=1930.05n

.meas tran vdout1_10ck1920 FIND v(dout1_10) AT=1930.05n

.meas tran vdout1_11ck1920 FIND v(dout1_11) AT=1930.05n

.meas tran vdout1_0ck1960 FIND v(dout1_0) AT=1970.05n

.meas tran vdout1_1ck1960 FIND v(dout1_1) AT=1970.05n

.meas tran vdout1_2ck1960 FIND v(dout1_2) AT=1970.05n

.meas tran vdout1_3ck1960 FIND v(dout1_3) AT=1970.05n

.meas tran vdout1_4ck1960 FIND v(dout1_4) AT=1970.05n

.meas tran vdout1_5ck1960 FIND v(dout1_5) AT=1970.05n

.meas tran vdout1_6ck1960 FIND v(dout1_6) AT=1970.05n

.meas tran vdout1_7ck1960 FIND v(dout1_7) AT=1970.05n

.meas tran vdout1_8ck1960 FIND v(dout1_8) AT=1970.05n

.meas tran vdout1_9ck1960 FIND v(dout1_9) AT=1970.05n

.meas tran vdout1_10ck1960 FIND v(dout1_10) AT=1970.05n

.meas tran vdout1_11ck1960 FIND v(dout1_11) AT=1970.05n

.meas tran vdout1_0ck1970 FIND v(dout1_0) AT=1980.05n

.meas tran vdout1_1ck1970 FIND v(dout1_1) AT=1980.05n

.meas tran vdout1_2ck1970 FIND v(dout1_2) AT=1980.05n

.meas tran vdout1_3ck1970 FIND v(dout1_3) AT=1980.05n

.meas tran vdout1_4ck1970 FIND v(dout1_4) AT=1980.05n

.meas tran vdout1_5ck1970 FIND v(dout1_5) AT=1980.05n

.meas tran vdout1_6ck1970 FIND v(dout1_6) AT=1980.05n

.meas tran vdout1_7ck1970 FIND v(dout1_7) AT=1980.05n

.meas tran vdout1_8ck1970 FIND v(dout1_8) AT=1980.05n

.meas tran vdout1_9ck1970 FIND v(dout1_9) AT=1980.05n

.meas tran vdout1_10ck1970 FIND v(dout1_10) AT=1980.05n

.meas tran vdout1_11ck1970 FIND v(dout1_11) AT=1980.05n

.meas tran vdout1_0ck2010 FIND v(dout1_0) AT=2020.05n

.meas tran vdout1_1ck2010 FIND v(dout1_1) AT=2020.05n

.meas tran vdout1_2ck2010 FIND v(dout1_2) AT=2020.05n

.meas tran vdout1_3ck2010 FIND v(dout1_3) AT=2020.05n

.meas tran vdout1_4ck2010 FIND v(dout1_4) AT=2020.05n

.meas tran vdout1_5ck2010 FIND v(dout1_5) AT=2020.05n

.meas tran vdout1_6ck2010 FIND v(dout1_6) AT=2020.05n

.meas tran vdout1_7ck2010 FIND v(dout1_7) AT=2020.05n

.meas tran vdout1_8ck2010 FIND v(dout1_8) AT=2020.05n

.meas tran vdout1_9ck2010 FIND v(dout1_9) AT=2020.05n

.meas tran vdout1_10ck2010 FIND v(dout1_10) AT=2020.05n

.meas tran vdout1_11ck2010 FIND v(dout1_11) AT=2020.05n

.meas tran vdout1_0ck2020 FIND v(dout1_0) AT=2030.05n

.meas tran vdout1_1ck2020 FIND v(dout1_1) AT=2030.05n

.meas tran vdout1_2ck2020 FIND v(dout1_2) AT=2030.05n

.meas tran vdout1_3ck2020 FIND v(dout1_3) AT=2030.05n

.meas tran vdout1_4ck2020 FIND v(dout1_4) AT=2030.05n

.meas tran vdout1_5ck2020 FIND v(dout1_5) AT=2030.05n

.meas tran vdout1_6ck2020 FIND v(dout1_6) AT=2030.05n

.meas tran vdout1_7ck2020 FIND v(dout1_7) AT=2030.05n

.meas tran vdout1_8ck2020 FIND v(dout1_8) AT=2030.05n

.meas tran vdout1_9ck2020 FIND v(dout1_9) AT=2030.05n

.meas tran vdout1_10ck2020 FIND v(dout1_10) AT=2030.05n

.meas tran vdout1_11ck2020 FIND v(dout1_11) AT=2030.05n

.meas tran vdout1_0ck2030 FIND v(dout1_0) AT=2040.05n

.meas tran vdout1_1ck2030 FIND v(dout1_1) AT=2040.05n

.meas tran vdout1_2ck2030 FIND v(dout1_2) AT=2040.05n

.meas tran vdout1_3ck2030 FIND v(dout1_3) AT=2040.05n

.meas tran vdout1_4ck2030 FIND v(dout1_4) AT=2040.05n

.meas tran vdout1_5ck2030 FIND v(dout1_5) AT=2040.05n

.meas tran vdout1_6ck2030 FIND v(dout1_6) AT=2040.05n

.meas tran vdout1_7ck2030 FIND v(dout1_7) AT=2040.05n

.meas tran vdout1_8ck2030 FIND v(dout1_8) AT=2040.05n

.meas tran vdout1_9ck2030 FIND v(dout1_9) AT=2040.05n

.meas tran vdout1_10ck2030 FIND v(dout1_10) AT=2040.05n

.meas tran vdout1_11ck2030 FIND v(dout1_11) AT=2040.05n

.meas tran vdout1_0ck2040 FIND v(dout1_0) AT=2050.05n

.meas tran vdout1_1ck2040 FIND v(dout1_1) AT=2050.05n

.meas tran vdout1_2ck2040 FIND v(dout1_2) AT=2050.05n

.meas tran vdout1_3ck2040 FIND v(dout1_3) AT=2050.05n

.meas tran vdout1_4ck2040 FIND v(dout1_4) AT=2050.05n

.meas tran vdout1_5ck2040 FIND v(dout1_5) AT=2050.05n

.meas tran vdout1_6ck2040 FIND v(dout1_6) AT=2050.05n

.meas tran vdout1_7ck2040 FIND v(dout1_7) AT=2050.05n

.meas tran vdout1_8ck2040 FIND v(dout1_8) AT=2050.05n

.meas tran vdout1_9ck2040 FIND v(dout1_9) AT=2050.05n

.meas tran vdout1_10ck2040 FIND v(dout1_10) AT=2050.05n

.meas tran vdout1_11ck2040 FIND v(dout1_11) AT=2050.05n
